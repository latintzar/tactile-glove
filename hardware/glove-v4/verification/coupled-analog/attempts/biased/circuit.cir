* V4 exact canonical shared tactile network, typical vendor macros
VRAIL 3V3_A 0 3.3
VREFERENCE VREF3V0 0 3
* Ideal settled rail/reference: excludes LDO/reference dynamics.
.ic v(VMID1V25)=1.25 v(VMID_DIV)=1.25 v(VMID_BUF_IN)=1.25 v(VEXC2V5)=2.5 v(VEXC_FB)=2.5 v(VEXC_DRV)=2.5 v(VEXC_DIV)=2.5 v(ADC_NEG_OUT)=1.25 v(ADC_AIN_n)=1.25
CEXTRA VMID1V25 0 1e-09
* All20 pressure contacts move from1Gohm to1ohm at95ms, release115ms.
VCONTACT contact_conductance 0 PWL(0 1n 95m 1n 95.001m 1 115m 1 115.001m 1n)
R_VEXC_H VREF3V0 VEXC_DIV 2k
R_VEXC_L VEXC_DIV 0 10k
R_VEXC_ISO VEXC_DRV VEXC2V5 47
R_VEXC_FB VEXC2V5 VEXC_FB 10k
C_VEXC_FB VEXC_DRV VEXC_FB 100n
C_VEXC VEXC2V5 0 1u
R_VMID_H VEXC2V5 VMID_DIV 10k
R_VMID_L VMID_DIV 0 10k
C_VMID VMID_DIV 0 1u
R_VMID_IN VMID_DIV VMID_BUF_IN 4.7k
R_ADC_NEG_ISO ADC_NEG_OUT ADC_AIN_n 22
C_ADC_NEG_BUCKET ADC_AIN_n 0 1n
XU_CHG1_0 VMID1V25 CHG_IN_I1 3V3_A 0 CHG_OUT_I1 MCP6001
XU_CHG1_1 VMID1V25 CHG_IN_I2 3V3_A 0 CHG_OUT_I2 MCP6001
XU_CHG1_2 VMID1V25 CHG_IN_I3 3V3_A 0 CHG_OUT_I3 MCP6001
XU_CHG1_3 VMID1V25 CHG_IN_M1 3V3_A 0 CHG_OUT_M1 MCP6001
XU_CHG2_0 VMID1V25 CHG_IN_M2 3V3_A 0 CHG_OUT_M2 MCP6001
XU_CHG2_1 VMID1V25 CHG_IN_M3 3V3_A 0 CHG_OUT_M3 MCP6001
XU_CHG2_2 VMID1V25 CHG_IN_R1 3V3_A 0 CHG_OUT_R1 MCP6001
XU_CHG2_3 VMID1V25 CHG_IN_R2 3V3_A 0 CHG_OUT_R2 MCP6001
XU_CHG3_0 VMID1V25 CHG_IN_R3 3V3_A 0 CHG_OUT_R3 MCP6001
XU_CHG3_1 VMID1V25 CHG_IN_L1 3V3_A 0 CHG_OUT_L1 MCP6001
XU_CHG3_2 VMID1V25 CHG_IN_L2 3V3_A 0 CHG_OUT_L2 MCP6001
XU_CHG3_3 VMID1V25 CHG_IN_L3 3V3_A 0 CHG_OUT_L3 MCP6001
XU_CHG4_0 VMID1V25 CHG_IN_T1 3V3_A 0 CHG_OUT_T1 MCP6001
XU_CHG4_1 VMID1V25 CHG_IN_T2 3V3_A 0 CHG_OUT_T2 MCP6001
XU_CHG4_2 VMID1V25 CHG_IN_P1 3V3_A 0 CHG_OUT_P1 MCP6001
XU_CHG4_3 VMID1V25 CHG_IN_P2 3V3_A 0 CHG_OUT_P2 MCP6001
XU_CHG5_0 VMID1V25 CHG_IN_P3 3V3_A 0 CHG_OUT_P3 MCP6001
XU_CHG5_1 VMID1V25 CHG_IN_P4 3V3_A 0 CHG_OUT_P4 MCP6001
XU_CHG5_2 VMID1V25 CHG_IN_H1 3V3_A 0 CHG_OUT_H1 MCP6001
XU_CHG5_3 VMID1V25 CHG_IN_H2 3V3_A 0 CHG_OUT_H2 MCP6001
XU_FILT1_0 S1_B_I1 S1_OUT_I1 3V3_A 0 S1_OUT_I1 MCP6001
XU_FILT1_1 S2_B_I1 S2_OUT_I1 3V3_A 0 S2_OUT_I1 MCP6001
XU_FILT1_2 S1_B_I2 S1_OUT_I2 3V3_A 0 S1_OUT_I2 MCP6001
XU_FILT1_3 S2_B_I2 S2_OUT_I2 3V3_A 0 S2_OUT_I2 MCP6001
XU_FILT2_0 S1_B_I3 S1_OUT_I3 3V3_A 0 S1_OUT_I3 MCP6001
XU_FILT2_1 S2_B_I3 S2_OUT_I3 3V3_A 0 S2_OUT_I3 MCP6001
XU_FILT2_2 S1_B_M1 S1_OUT_M1 3V3_A 0 S1_OUT_M1 MCP6001
XU_FILT2_3 S2_B_M1 S2_OUT_M1 3V3_A 0 S2_OUT_M1 MCP6001
XU_FILT3_0 S1_B_M2 S1_OUT_M2 3V3_A 0 S1_OUT_M2 MCP6001
XU_FILT3_1 S2_B_M2 S2_OUT_M2 3V3_A 0 S2_OUT_M2 MCP6001
XU_FILT3_2 S1_B_M3 S1_OUT_M3 3V3_A 0 S1_OUT_M3 MCP6001
XU_FILT3_3 S2_B_M3 S2_OUT_M3 3V3_A 0 S2_OUT_M3 MCP6001
XU_FILT4_0 S1_B_R1 S1_OUT_R1 3V3_A 0 S1_OUT_R1 MCP6001
XU_FILT4_1 S2_B_R1 S2_OUT_R1 3V3_A 0 S2_OUT_R1 MCP6001
XU_FILT4_2 S1_B_R2 S1_OUT_R2 3V3_A 0 S1_OUT_R2 MCP6001
XU_FILT4_3 S2_B_R2 S2_OUT_R2 3V3_A 0 S2_OUT_R2 MCP6001
XU_FILT5_0 S1_B_R3 S1_OUT_R3 3V3_A 0 S1_OUT_R3 MCP6001
XU_FILT5_1 S2_B_R3 S2_OUT_R3 3V3_A 0 S2_OUT_R3 MCP6001
XU_FILT5_2 S1_B_L1 S1_OUT_L1 3V3_A 0 S1_OUT_L1 MCP6001
XU_FILT5_3 S2_B_L1 S2_OUT_L1 3V3_A 0 S2_OUT_L1 MCP6001
XU_FILT6_0 S1_B_L2 S1_OUT_L2 3V3_A 0 S1_OUT_L2 MCP6001
XU_FILT6_1 S2_B_L2 S2_OUT_L2 3V3_A 0 S2_OUT_L2 MCP6001
XU_FILT6_2 S1_B_L3 S1_OUT_L3 3V3_A 0 S1_OUT_L3 MCP6001
XU_FILT6_3 S2_B_L3 S2_OUT_L3 3V3_A 0 S2_OUT_L3 MCP6001
XU_FILT7_0 S1_B_T1 S1_OUT_T1 3V3_A 0 S1_OUT_T1 MCP6001
XU_FILT7_1 S2_B_T1 S2_OUT_T1 3V3_A 0 S2_OUT_T1 MCP6001
XU_FILT7_2 S1_B_T2 S1_OUT_T2 3V3_A 0 S1_OUT_T2 MCP6001
XU_FILT7_3 S2_B_T2 S2_OUT_T2 3V3_A 0 S2_OUT_T2 MCP6001
XU_FILT8_0 S1_B_P1 S1_OUT_P1 3V3_A 0 S1_OUT_P1 MCP6001
XU_FILT8_1 S2_B_P1 S2_OUT_P1 3V3_A 0 S2_OUT_P1 MCP6001
XU_FILT8_2 S1_B_P2 S1_OUT_P2 3V3_A 0 S1_OUT_P2 MCP6001
XU_FILT8_3 S2_B_P2 S2_OUT_P2 3V3_A 0 S2_OUT_P2 MCP6001
XU_FILT9_0 S1_B_P3 S1_OUT_P3 3V3_A 0 S1_OUT_P3 MCP6001
XU_FILT9_1 S2_B_P3 S2_OUT_P3 3V3_A 0 S2_OUT_P3 MCP6001
XU_FILT9_2 S1_B_P4 S1_OUT_P4 3V3_A 0 S1_OUT_P4 MCP6001
XU_FILT9_3 S2_B_P4 S2_OUT_P4 3V3_A 0 S2_OUT_P4 MCP6001
XU_FILT10_0 S1_B_H1 S1_OUT_H1 3V3_A 0 S1_OUT_H1 MCP6001
XU_FILT10_1 S2_B_H1 S2_OUT_H1 3V3_A 0 S2_OUT_H1 MCP6001
XU_FILT10_2 S1_B_H2 S1_OUT_H2 3V3_A 0 S1_OUT_H2 MCP6001
XU_FILT10_3 S2_B_H2 S2_OUT_H2 3V3_A 0 S2_OUT_H2 MCP6001
XBIAS0 VEXC_DIV VEXC_FB 3V3_A 0 VEXC_DRV MCP6001
XBIAS1 VMID_BUF_IN VMID1V25 3V3_A 0 VMID1V25 MCP6001
XNEG VMID1V25 ADC_NEG_OUT 3V3_A 0 ADC_NEG_OUT opa320_OPAx320
RFB_I1 CHG_OUT_I1 CHG_IN_I1 22Meg
CFB_I1 CHG_OUT_I1 CHG_IN_I1 470p
RIN_I1 PVDF_I1 CHG_IN_I1 100k
RS1A_I1 CHG_OUT_I1 S1_A_I1 14.7k
RS1B_I1 S1_A_I1 S1_B_I1 14.7k
CS1FB_I1 S1_A_I1 S1_OUT_I1 12n
CS1G_I1 S1_B_I1 VMID1V25 10n
RS2A_I1 S1_OUT_I1 S2_A_I1 27.4k
RS2B_I1 S2_A_I1 S2_B_I1 27.4k
CS2FB_I1 S2_A_I1 S2_OUT_I1 15n
CS2G_I1 S2_B_I1 VMID1V25 2.2n
RPD_I1 PRESS_I1 0 10k
DCLP_I1 CHG_IN_I1 VMID1V25 BAV199
DCLN_I1 VMID1V25 CHG_IN_I1 BAV199
CPV_I1 PVDF_I1 0 531p
CCABLE_I1 PVDF_I1 0 150p
CLOAD_I1 S2_OUT_I1 0 5p
BPC_I1 VEXC2V5 PRESS_I1 I=V(VEXC2V5,PRESS_I1)*V(contact_conductance)
IPULSE_I1 0 PVDF_I1 PULSE(0 250u 80m 100n 100n 900n 1s)
.ic v(PVDF_I1)=1.25
.ic v(CHG_IN_I1)=1.25
.ic v(CHG_OUT_I1)=1.25
.ic v(S1_A_I1)=1.25
.ic v(S1_B_I1)=1.25
.ic v(S1_OUT_I1)=1.25
.ic v(S2_A_I1)=1.25
.ic v(S2_B_I1)=1.25
.ic v(S2_OUT_I1)=1.25
RFB_I2 CHG_OUT_I2 CHG_IN_I2 22Meg
CFB_I2 CHG_OUT_I2 CHG_IN_I2 470p
RIN_I2 PVDF_I2 CHG_IN_I2 100k
RS1A_I2 CHG_OUT_I2 S1_A_I2 14.7k
RS1B_I2 S1_A_I2 S1_B_I2 14.7k
CS1FB_I2 S1_A_I2 S1_OUT_I2 12n
CS1G_I2 S1_B_I2 VMID1V25 10n
RS2A_I2 S1_OUT_I2 S2_A_I2 27.4k
RS2B_I2 S2_A_I2 S2_B_I2 27.4k
CS2FB_I2 S2_A_I2 S2_OUT_I2 15n
CS2G_I2 S2_B_I2 VMID1V25 2.2n
RPD_I2 PRESS_I2 0 10k
DCLP_I2 CHG_IN_I2 VMID1V25 BAV199
DCLN_I2 VMID1V25 CHG_IN_I2 BAV199
CPV_I2 PVDF_I2 0 531p
CCABLE_I2 PVDF_I2 0 150p
CLOAD_I2 S2_OUT_I2 0 5p
BPC_I2 VEXC2V5 PRESS_I2 I=V(VEXC2V5,PRESS_I2)*V(contact_conductance)
.ic v(PVDF_I2)=1.25
.ic v(CHG_IN_I2)=1.25
.ic v(CHG_OUT_I2)=1.25
.ic v(S1_A_I2)=1.25
.ic v(S1_B_I2)=1.25
.ic v(S1_OUT_I2)=1.25
.ic v(S2_A_I2)=1.25
.ic v(S2_B_I2)=1.25
.ic v(S2_OUT_I2)=1.25
RFB_I3 CHG_OUT_I3 CHG_IN_I3 22Meg
CFB_I3 CHG_OUT_I3 CHG_IN_I3 470p
RIN_I3 PVDF_I3 CHG_IN_I3 100k
RS1A_I3 CHG_OUT_I3 S1_A_I3 14.7k
RS1B_I3 S1_A_I3 S1_B_I3 14.7k
CS1FB_I3 S1_A_I3 S1_OUT_I3 12n
CS1G_I3 S1_B_I3 VMID1V25 10n
RS2A_I3 S1_OUT_I3 S2_A_I3 27.4k
RS2B_I3 S2_A_I3 S2_B_I3 27.4k
CS2FB_I3 S2_A_I3 S2_OUT_I3 15n
CS2G_I3 S2_B_I3 VMID1V25 2.2n
RPD_I3 PRESS_I3 0 10k
DCLP_I3 CHG_IN_I3 VMID1V25 BAV199
DCLN_I3 VMID1V25 CHG_IN_I3 BAV199
CPV_I3 PVDF_I3 0 531p
CCABLE_I3 PVDF_I3 0 150p
CLOAD_I3 S2_OUT_I3 0 5p
BPC_I3 VEXC2V5 PRESS_I3 I=V(VEXC2V5,PRESS_I3)*V(contact_conductance)
.ic v(PVDF_I3)=1.25
.ic v(CHG_IN_I3)=1.25
.ic v(CHG_OUT_I3)=1.25
.ic v(S1_A_I3)=1.25
.ic v(S1_B_I3)=1.25
.ic v(S1_OUT_I3)=1.25
.ic v(S2_A_I3)=1.25
.ic v(S2_B_I3)=1.25
.ic v(S2_OUT_I3)=1.25
RFB_M1 CHG_OUT_M1 CHG_IN_M1 22Meg
CFB_M1 CHG_OUT_M1 CHG_IN_M1 470p
RIN_M1 PVDF_M1 CHG_IN_M1 100k
RS1A_M1 CHG_OUT_M1 S1_A_M1 14.7k
RS1B_M1 S1_A_M1 S1_B_M1 14.7k
CS1FB_M1 S1_A_M1 S1_OUT_M1 12n
CS1G_M1 S1_B_M1 VMID1V25 10n
RS2A_M1 S1_OUT_M1 S2_A_M1 27.4k
RS2B_M1 S2_A_M1 S2_B_M1 27.4k
CS2FB_M1 S2_A_M1 S2_OUT_M1 15n
CS2G_M1 S2_B_M1 VMID1V25 2.2n
RPD_M1 PRESS_M1 0 10k
DCLP_M1 CHG_IN_M1 VMID1V25 BAV199
DCLN_M1 VMID1V25 CHG_IN_M1 BAV199
CPV_M1 PVDF_M1 0 531p
CCABLE_M1 PVDF_M1 0 150p
CLOAD_M1 S2_OUT_M1 0 5p
BPC_M1 VEXC2V5 PRESS_M1 I=V(VEXC2V5,PRESS_M1)*V(contact_conductance)
.ic v(PVDF_M1)=1.25
.ic v(CHG_IN_M1)=1.25
.ic v(CHG_OUT_M1)=1.25
.ic v(S1_A_M1)=1.25
.ic v(S1_B_M1)=1.25
.ic v(S1_OUT_M1)=1.25
.ic v(S2_A_M1)=1.25
.ic v(S2_B_M1)=1.25
.ic v(S2_OUT_M1)=1.25
RFB_M2 CHG_OUT_M2 CHG_IN_M2 22Meg
CFB_M2 CHG_OUT_M2 CHG_IN_M2 470p
RIN_M2 PVDF_M2 CHG_IN_M2 100k
RS1A_M2 CHG_OUT_M2 S1_A_M2 14.7k
RS1B_M2 S1_A_M2 S1_B_M2 14.7k
CS1FB_M2 S1_A_M2 S1_OUT_M2 12n
CS1G_M2 S1_B_M2 VMID1V25 10n
RS2A_M2 S1_OUT_M2 S2_A_M2 27.4k
RS2B_M2 S2_A_M2 S2_B_M2 27.4k
CS2FB_M2 S2_A_M2 S2_OUT_M2 15n
CS2G_M2 S2_B_M2 VMID1V25 2.2n
RPD_M2 PRESS_M2 0 10k
DCLP_M2 CHG_IN_M2 VMID1V25 BAV199
DCLN_M2 VMID1V25 CHG_IN_M2 BAV199
CPV_M2 PVDF_M2 0 531p
CCABLE_M2 PVDF_M2 0 150p
CLOAD_M2 S2_OUT_M2 0 5p
BPC_M2 VEXC2V5 PRESS_M2 I=V(VEXC2V5,PRESS_M2)*V(contact_conductance)
.ic v(PVDF_M2)=1.25
.ic v(CHG_IN_M2)=1.25
.ic v(CHG_OUT_M2)=1.25
.ic v(S1_A_M2)=1.25
.ic v(S1_B_M2)=1.25
.ic v(S1_OUT_M2)=1.25
.ic v(S2_A_M2)=1.25
.ic v(S2_B_M2)=1.25
.ic v(S2_OUT_M2)=1.25
RFB_M3 CHG_OUT_M3 CHG_IN_M3 22Meg
CFB_M3 CHG_OUT_M3 CHG_IN_M3 470p
RIN_M3 PVDF_M3 CHG_IN_M3 100k
RS1A_M3 CHG_OUT_M3 S1_A_M3 14.7k
RS1B_M3 S1_A_M3 S1_B_M3 14.7k
CS1FB_M3 S1_A_M3 S1_OUT_M3 12n
CS1G_M3 S1_B_M3 VMID1V25 10n
RS2A_M3 S1_OUT_M3 S2_A_M3 27.4k
RS2B_M3 S2_A_M3 S2_B_M3 27.4k
CS2FB_M3 S2_A_M3 S2_OUT_M3 15n
CS2G_M3 S2_B_M3 VMID1V25 2.2n
RPD_M3 PRESS_M3 0 10k
DCLP_M3 CHG_IN_M3 VMID1V25 BAV199
DCLN_M3 VMID1V25 CHG_IN_M3 BAV199
CPV_M3 PVDF_M3 0 531p
CCABLE_M3 PVDF_M3 0 150p
CLOAD_M3 S2_OUT_M3 0 5p
BPC_M3 VEXC2V5 PRESS_M3 I=V(VEXC2V5,PRESS_M3)*V(contact_conductance)
.ic v(PVDF_M3)=1.25
.ic v(CHG_IN_M3)=1.25
.ic v(CHG_OUT_M3)=1.25
.ic v(S1_A_M3)=1.25
.ic v(S1_B_M3)=1.25
.ic v(S1_OUT_M3)=1.25
.ic v(S2_A_M3)=1.25
.ic v(S2_B_M3)=1.25
.ic v(S2_OUT_M3)=1.25
RFB_R1 CHG_OUT_R1 CHG_IN_R1 22Meg
CFB_R1 CHG_OUT_R1 CHG_IN_R1 470p
RIN_R1 PVDF_R1 CHG_IN_R1 100k
RS1A_R1 CHG_OUT_R1 S1_A_R1 14.7k
RS1B_R1 S1_A_R1 S1_B_R1 14.7k
CS1FB_R1 S1_A_R1 S1_OUT_R1 12n
CS1G_R1 S1_B_R1 VMID1V25 10n
RS2A_R1 S1_OUT_R1 S2_A_R1 27.4k
RS2B_R1 S2_A_R1 S2_B_R1 27.4k
CS2FB_R1 S2_A_R1 S2_OUT_R1 15n
CS2G_R1 S2_B_R1 VMID1V25 2.2n
RPD_R1 PRESS_R1 0 10k
DCLP_R1 CHG_IN_R1 VMID1V25 BAV199
DCLN_R1 VMID1V25 CHG_IN_R1 BAV199
CPV_R1 PVDF_R1 0 531p
CCABLE_R1 PVDF_R1 0 150p
CLOAD_R1 S2_OUT_R1 0 5p
BPC_R1 VEXC2V5 PRESS_R1 I=V(VEXC2V5,PRESS_R1)*V(contact_conductance)
.ic v(PVDF_R1)=1.25
.ic v(CHG_IN_R1)=1.25
.ic v(CHG_OUT_R1)=1.25
.ic v(S1_A_R1)=1.25
.ic v(S1_B_R1)=1.25
.ic v(S1_OUT_R1)=1.25
.ic v(S2_A_R1)=1.25
.ic v(S2_B_R1)=1.25
.ic v(S2_OUT_R1)=1.25
RFB_R2 CHG_OUT_R2 CHG_IN_R2 22Meg
CFB_R2 CHG_OUT_R2 CHG_IN_R2 470p
RIN_R2 PVDF_R2 CHG_IN_R2 100k
RS1A_R2 CHG_OUT_R2 S1_A_R2 14.7k
RS1B_R2 S1_A_R2 S1_B_R2 14.7k
CS1FB_R2 S1_A_R2 S1_OUT_R2 12n
CS1G_R2 S1_B_R2 VMID1V25 10n
RS2A_R2 S1_OUT_R2 S2_A_R2 27.4k
RS2B_R2 S2_A_R2 S2_B_R2 27.4k
CS2FB_R2 S2_A_R2 S2_OUT_R2 15n
CS2G_R2 S2_B_R2 VMID1V25 2.2n
RPD_R2 PRESS_R2 0 10k
DCLP_R2 CHG_IN_R2 VMID1V25 BAV199
DCLN_R2 VMID1V25 CHG_IN_R2 BAV199
CPV_R2 PVDF_R2 0 531p
CCABLE_R2 PVDF_R2 0 150p
CLOAD_R2 S2_OUT_R2 0 5p
BPC_R2 VEXC2V5 PRESS_R2 I=V(VEXC2V5,PRESS_R2)*V(contact_conductance)
.ic v(PVDF_R2)=1.25
.ic v(CHG_IN_R2)=1.25
.ic v(CHG_OUT_R2)=1.25
.ic v(S1_A_R2)=1.25
.ic v(S1_B_R2)=1.25
.ic v(S1_OUT_R2)=1.25
.ic v(S2_A_R2)=1.25
.ic v(S2_B_R2)=1.25
.ic v(S2_OUT_R2)=1.25
RFB_R3 CHG_OUT_R3 CHG_IN_R3 22Meg
CFB_R3 CHG_OUT_R3 CHG_IN_R3 470p
RIN_R3 PVDF_R3 CHG_IN_R3 100k
RS1A_R3 CHG_OUT_R3 S1_A_R3 14.7k
RS1B_R3 S1_A_R3 S1_B_R3 14.7k
CS1FB_R3 S1_A_R3 S1_OUT_R3 12n
CS1G_R3 S1_B_R3 VMID1V25 10n
RS2A_R3 S1_OUT_R3 S2_A_R3 27.4k
RS2B_R3 S2_A_R3 S2_B_R3 27.4k
CS2FB_R3 S2_A_R3 S2_OUT_R3 15n
CS2G_R3 S2_B_R3 VMID1V25 2.2n
RPD_R3 PRESS_R3 0 10k
DCLP_R3 CHG_IN_R3 VMID1V25 BAV199
DCLN_R3 VMID1V25 CHG_IN_R3 BAV199
CPV_R3 PVDF_R3 0 531p
CCABLE_R3 PVDF_R3 0 150p
CLOAD_R3 S2_OUT_R3 0 5p
BPC_R3 VEXC2V5 PRESS_R3 I=V(VEXC2V5,PRESS_R3)*V(contact_conductance)
.ic v(PVDF_R3)=1.25
.ic v(CHG_IN_R3)=1.25
.ic v(CHG_OUT_R3)=1.25
.ic v(S1_A_R3)=1.25
.ic v(S1_B_R3)=1.25
.ic v(S1_OUT_R3)=1.25
.ic v(S2_A_R3)=1.25
.ic v(S2_B_R3)=1.25
.ic v(S2_OUT_R3)=1.25
RFB_L1 CHG_OUT_L1 CHG_IN_L1 22Meg
CFB_L1 CHG_OUT_L1 CHG_IN_L1 470p
RIN_L1 PVDF_L1 CHG_IN_L1 100k
RS1A_L1 CHG_OUT_L1 S1_A_L1 14.7k
RS1B_L1 S1_A_L1 S1_B_L1 14.7k
CS1FB_L1 S1_A_L1 S1_OUT_L1 12n
CS1G_L1 S1_B_L1 VMID1V25 10n
RS2A_L1 S1_OUT_L1 S2_A_L1 27.4k
RS2B_L1 S2_A_L1 S2_B_L1 27.4k
CS2FB_L1 S2_A_L1 S2_OUT_L1 15n
CS2G_L1 S2_B_L1 VMID1V25 2.2n
RPD_L1 PRESS_L1 0 10k
DCLP_L1 CHG_IN_L1 VMID1V25 BAV199
DCLN_L1 VMID1V25 CHG_IN_L1 BAV199
CPV_L1 PVDF_L1 0 531p
CCABLE_L1 PVDF_L1 0 150p
CLOAD_L1 S2_OUT_L1 0 5p
BPC_L1 VEXC2V5 PRESS_L1 I=V(VEXC2V5,PRESS_L1)*V(contact_conductance)
.ic v(PVDF_L1)=1.25
.ic v(CHG_IN_L1)=1.25
.ic v(CHG_OUT_L1)=1.25
.ic v(S1_A_L1)=1.25
.ic v(S1_B_L1)=1.25
.ic v(S1_OUT_L1)=1.25
.ic v(S2_A_L1)=1.25
.ic v(S2_B_L1)=1.25
.ic v(S2_OUT_L1)=1.25
RFB_L2 CHG_OUT_L2 CHG_IN_L2 22Meg
CFB_L2 CHG_OUT_L2 CHG_IN_L2 470p
RIN_L2 PVDF_L2 CHG_IN_L2 100k
RS1A_L2 CHG_OUT_L2 S1_A_L2 14.7k
RS1B_L2 S1_A_L2 S1_B_L2 14.7k
CS1FB_L2 S1_A_L2 S1_OUT_L2 12n
CS1G_L2 S1_B_L2 VMID1V25 10n
RS2A_L2 S1_OUT_L2 S2_A_L2 27.4k
RS2B_L2 S2_A_L2 S2_B_L2 27.4k
CS2FB_L2 S2_A_L2 S2_OUT_L2 15n
CS2G_L2 S2_B_L2 VMID1V25 2.2n
RPD_L2 PRESS_L2 0 10k
DCLP_L2 CHG_IN_L2 VMID1V25 BAV199
DCLN_L2 VMID1V25 CHG_IN_L2 BAV199
CPV_L2 PVDF_L2 0 531p
CCABLE_L2 PVDF_L2 0 150p
CLOAD_L2 S2_OUT_L2 0 5p
BPC_L2 VEXC2V5 PRESS_L2 I=V(VEXC2V5,PRESS_L2)*V(contact_conductance)
.ic v(PVDF_L2)=1.25
.ic v(CHG_IN_L2)=1.25
.ic v(CHG_OUT_L2)=1.25
.ic v(S1_A_L2)=1.25
.ic v(S1_B_L2)=1.25
.ic v(S1_OUT_L2)=1.25
.ic v(S2_A_L2)=1.25
.ic v(S2_B_L2)=1.25
.ic v(S2_OUT_L2)=1.25
RFB_L3 CHG_OUT_L3 CHG_IN_L3 22Meg
CFB_L3 CHG_OUT_L3 CHG_IN_L3 470p
RIN_L3 PVDF_L3 CHG_IN_L3 100k
RS1A_L3 CHG_OUT_L3 S1_A_L3 14.7k
RS1B_L3 S1_A_L3 S1_B_L3 14.7k
CS1FB_L3 S1_A_L3 S1_OUT_L3 12n
CS1G_L3 S1_B_L3 VMID1V25 10n
RS2A_L3 S1_OUT_L3 S2_A_L3 27.4k
RS2B_L3 S2_A_L3 S2_B_L3 27.4k
CS2FB_L3 S2_A_L3 S2_OUT_L3 15n
CS2G_L3 S2_B_L3 VMID1V25 2.2n
RPD_L3 PRESS_L3 0 10k
DCLP_L3 CHG_IN_L3 VMID1V25 BAV199
DCLN_L3 VMID1V25 CHG_IN_L3 BAV199
CPV_L3 PVDF_L3 0 531p
CCABLE_L3 PVDF_L3 0 150p
CLOAD_L3 S2_OUT_L3 0 5p
BPC_L3 VEXC2V5 PRESS_L3 I=V(VEXC2V5,PRESS_L3)*V(contact_conductance)
.ic v(PVDF_L3)=1.25
.ic v(CHG_IN_L3)=1.25
.ic v(CHG_OUT_L3)=1.25
.ic v(S1_A_L3)=1.25
.ic v(S1_B_L3)=1.25
.ic v(S1_OUT_L3)=1.25
.ic v(S2_A_L3)=1.25
.ic v(S2_B_L3)=1.25
.ic v(S2_OUT_L3)=1.25
RFB_T1 CHG_OUT_T1 CHG_IN_T1 22Meg
CFB_T1 CHG_OUT_T1 CHG_IN_T1 470p
RIN_T1 PVDF_T1 CHG_IN_T1 100k
RS1A_T1 CHG_OUT_T1 S1_A_T1 14.7k
RS1B_T1 S1_A_T1 S1_B_T1 14.7k
CS1FB_T1 S1_A_T1 S1_OUT_T1 12n
CS1G_T1 S1_B_T1 VMID1V25 10n
RS2A_T1 S1_OUT_T1 S2_A_T1 27.4k
RS2B_T1 S2_A_T1 S2_B_T1 27.4k
CS2FB_T1 S2_A_T1 S2_OUT_T1 15n
CS2G_T1 S2_B_T1 VMID1V25 2.2n
RPD_T1 PRESS_T1 0 10k
DCLP_T1 CHG_IN_T1 VMID1V25 BAV199
DCLN_T1 VMID1V25 CHG_IN_T1 BAV199
CPV_T1 PVDF_T1 0 531p
CCABLE_T1 PVDF_T1 0 150p
CLOAD_T1 S2_OUT_T1 0 5p
BPC_T1 VEXC2V5 PRESS_T1 I=V(VEXC2V5,PRESS_T1)*V(contact_conductance)
.ic v(PVDF_T1)=1.25
.ic v(CHG_IN_T1)=1.25
.ic v(CHG_OUT_T1)=1.25
.ic v(S1_A_T1)=1.25
.ic v(S1_B_T1)=1.25
.ic v(S1_OUT_T1)=1.25
.ic v(S2_A_T1)=1.25
.ic v(S2_B_T1)=1.25
.ic v(S2_OUT_T1)=1.25
RFB_T2 CHG_OUT_T2 CHG_IN_T2 22Meg
CFB_T2 CHG_OUT_T2 CHG_IN_T2 470p
RIN_T2 PVDF_T2 CHG_IN_T2 100k
RS1A_T2 CHG_OUT_T2 S1_A_T2 14.7k
RS1B_T2 S1_A_T2 S1_B_T2 14.7k
CS1FB_T2 S1_A_T2 S1_OUT_T2 12n
CS1G_T2 S1_B_T2 VMID1V25 10n
RS2A_T2 S1_OUT_T2 S2_A_T2 27.4k
RS2B_T2 S2_A_T2 S2_B_T2 27.4k
CS2FB_T2 S2_A_T2 S2_OUT_T2 15n
CS2G_T2 S2_B_T2 VMID1V25 2.2n
RPD_T2 PRESS_T2 0 10k
DCLP_T2 CHG_IN_T2 VMID1V25 BAV199
DCLN_T2 VMID1V25 CHG_IN_T2 BAV199
CPV_T2 PVDF_T2 0 531p
CCABLE_T2 PVDF_T2 0 150p
CLOAD_T2 S2_OUT_T2 0 5p
BPC_T2 VEXC2V5 PRESS_T2 I=V(VEXC2V5,PRESS_T2)*V(contact_conductance)
.ic v(PVDF_T2)=1.25
.ic v(CHG_IN_T2)=1.25
.ic v(CHG_OUT_T2)=1.25
.ic v(S1_A_T2)=1.25
.ic v(S1_B_T2)=1.25
.ic v(S1_OUT_T2)=1.25
.ic v(S2_A_T2)=1.25
.ic v(S2_B_T2)=1.25
.ic v(S2_OUT_T2)=1.25
RFB_P1 CHG_OUT_P1 CHG_IN_P1 22Meg
CFB_P1 CHG_OUT_P1 CHG_IN_P1 470p
RIN_P1 PVDF_P1 CHG_IN_P1 100k
RS1A_P1 CHG_OUT_P1 S1_A_P1 14.7k
RS1B_P1 S1_A_P1 S1_B_P1 14.7k
CS1FB_P1 S1_A_P1 S1_OUT_P1 12n
CS1G_P1 S1_B_P1 VMID1V25 10n
RS2A_P1 S1_OUT_P1 S2_A_P1 27.4k
RS2B_P1 S2_A_P1 S2_B_P1 27.4k
CS2FB_P1 S2_A_P1 S2_OUT_P1 15n
CS2G_P1 S2_B_P1 VMID1V25 2.2n
RPD_P1 PRESS_P1 0 10k
DCLP_P1 CHG_IN_P1 VMID1V25 BAV199
DCLN_P1 VMID1V25 CHG_IN_P1 BAV199
CPV_P1 PVDF_P1 0 531p
CCABLE_P1 PVDF_P1 0 150p
CLOAD_P1 S2_OUT_P1 0 5p
BPC_P1 VEXC2V5 PRESS_P1 I=V(VEXC2V5,PRESS_P1)*V(contact_conductance)
.ic v(PVDF_P1)=1.25
.ic v(CHG_IN_P1)=1.25
.ic v(CHG_OUT_P1)=1.25
.ic v(S1_A_P1)=1.25
.ic v(S1_B_P1)=1.25
.ic v(S1_OUT_P1)=1.25
.ic v(S2_A_P1)=1.25
.ic v(S2_B_P1)=1.25
.ic v(S2_OUT_P1)=1.25
RFB_P2 CHG_OUT_P2 CHG_IN_P2 22Meg
CFB_P2 CHG_OUT_P2 CHG_IN_P2 470p
RIN_P2 PVDF_P2 CHG_IN_P2 100k
RS1A_P2 CHG_OUT_P2 S1_A_P2 14.7k
RS1B_P2 S1_A_P2 S1_B_P2 14.7k
CS1FB_P2 S1_A_P2 S1_OUT_P2 12n
CS1G_P2 S1_B_P2 VMID1V25 10n
RS2A_P2 S1_OUT_P2 S2_A_P2 27.4k
RS2B_P2 S2_A_P2 S2_B_P2 27.4k
CS2FB_P2 S2_A_P2 S2_OUT_P2 15n
CS2G_P2 S2_B_P2 VMID1V25 2.2n
RPD_P2 PRESS_P2 0 10k
DCLP_P2 CHG_IN_P2 VMID1V25 BAV199
DCLN_P2 VMID1V25 CHG_IN_P2 BAV199
CPV_P2 PVDF_P2 0 531p
CCABLE_P2 PVDF_P2 0 150p
CLOAD_P2 S2_OUT_P2 0 5p
BPC_P2 VEXC2V5 PRESS_P2 I=V(VEXC2V5,PRESS_P2)*V(contact_conductance)
.ic v(PVDF_P2)=1.25
.ic v(CHG_IN_P2)=1.25
.ic v(CHG_OUT_P2)=1.25
.ic v(S1_A_P2)=1.25
.ic v(S1_B_P2)=1.25
.ic v(S1_OUT_P2)=1.25
.ic v(S2_A_P2)=1.25
.ic v(S2_B_P2)=1.25
.ic v(S2_OUT_P2)=1.25
RFB_P3 CHG_OUT_P3 CHG_IN_P3 22Meg
CFB_P3 CHG_OUT_P3 CHG_IN_P3 470p
RIN_P3 PVDF_P3 CHG_IN_P3 100k
RS1A_P3 CHG_OUT_P3 S1_A_P3 14.7k
RS1B_P3 S1_A_P3 S1_B_P3 14.7k
CS1FB_P3 S1_A_P3 S1_OUT_P3 12n
CS1G_P3 S1_B_P3 VMID1V25 10n
RS2A_P3 S1_OUT_P3 S2_A_P3 27.4k
RS2B_P3 S2_A_P3 S2_B_P3 27.4k
CS2FB_P3 S2_A_P3 S2_OUT_P3 15n
CS2G_P3 S2_B_P3 VMID1V25 2.2n
RPD_P3 PRESS_P3 0 10k
DCLP_P3 CHG_IN_P3 VMID1V25 BAV199
DCLN_P3 VMID1V25 CHG_IN_P3 BAV199
CPV_P3 PVDF_P3 0 531p
CCABLE_P3 PVDF_P3 0 150p
CLOAD_P3 S2_OUT_P3 0 5p
BPC_P3 VEXC2V5 PRESS_P3 I=V(VEXC2V5,PRESS_P3)*V(contact_conductance)
.ic v(PVDF_P3)=1.25
.ic v(CHG_IN_P3)=1.25
.ic v(CHG_OUT_P3)=1.25
.ic v(S1_A_P3)=1.25
.ic v(S1_B_P3)=1.25
.ic v(S1_OUT_P3)=1.25
.ic v(S2_A_P3)=1.25
.ic v(S2_B_P3)=1.25
.ic v(S2_OUT_P3)=1.25
RFB_P4 CHG_OUT_P4 CHG_IN_P4 22Meg
CFB_P4 CHG_OUT_P4 CHG_IN_P4 470p
RIN_P4 PVDF_P4 CHG_IN_P4 100k
RS1A_P4 CHG_OUT_P4 S1_A_P4 14.7k
RS1B_P4 S1_A_P4 S1_B_P4 14.7k
CS1FB_P4 S1_A_P4 S1_OUT_P4 12n
CS1G_P4 S1_B_P4 VMID1V25 10n
RS2A_P4 S1_OUT_P4 S2_A_P4 27.4k
RS2B_P4 S2_A_P4 S2_B_P4 27.4k
CS2FB_P4 S2_A_P4 S2_OUT_P4 15n
CS2G_P4 S2_B_P4 VMID1V25 2.2n
RPD_P4 PRESS_P4 0 10k
DCLP_P4 CHG_IN_P4 VMID1V25 BAV199
DCLN_P4 VMID1V25 CHG_IN_P4 BAV199
CPV_P4 PVDF_P4 0 531p
CCABLE_P4 PVDF_P4 0 150p
CLOAD_P4 S2_OUT_P4 0 5p
BPC_P4 VEXC2V5 PRESS_P4 I=V(VEXC2V5,PRESS_P4)*V(contact_conductance)
.ic v(PVDF_P4)=1.25
.ic v(CHG_IN_P4)=1.25
.ic v(CHG_OUT_P4)=1.25
.ic v(S1_A_P4)=1.25
.ic v(S1_B_P4)=1.25
.ic v(S1_OUT_P4)=1.25
.ic v(S2_A_P4)=1.25
.ic v(S2_B_P4)=1.25
.ic v(S2_OUT_P4)=1.25
RFB_H1 CHG_OUT_H1 CHG_IN_H1 22Meg
CFB_H1 CHG_OUT_H1 CHG_IN_H1 470p
RIN_H1 PVDF_H1 CHG_IN_H1 100k
RS1A_H1 CHG_OUT_H1 S1_A_H1 14.7k
RS1B_H1 S1_A_H1 S1_B_H1 14.7k
CS1FB_H1 S1_A_H1 S1_OUT_H1 12n
CS1G_H1 S1_B_H1 VMID1V25 10n
RS2A_H1 S1_OUT_H1 S2_A_H1 27.4k
RS2B_H1 S2_A_H1 S2_B_H1 27.4k
CS2FB_H1 S2_A_H1 S2_OUT_H1 15n
CS2G_H1 S2_B_H1 VMID1V25 2.2n
RPD_H1 PRESS_H1 0 10k
DCLP_H1 CHG_IN_H1 VMID1V25 BAV199
DCLN_H1 VMID1V25 CHG_IN_H1 BAV199
CPV_H1 PVDF_H1 0 531p
CCABLE_H1 PVDF_H1 0 150p
CLOAD_H1 S2_OUT_H1 0 5p
BPC_H1 VEXC2V5 PRESS_H1 I=V(VEXC2V5,PRESS_H1)*V(contact_conductance)
.ic v(PVDF_H1)=1.25
.ic v(CHG_IN_H1)=1.25
.ic v(CHG_OUT_H1)=1.25
.ic v(S1_A_H1)=1.25
.ic v(S1_B_H1)=1.25
.ic v(S1_OUT_H1)=1.25
.ic v(S2_A_H1)=1.25
.ic v(S2_B_H1)=1.25
.ic v(S2_OUT_H1)=1.25
RFB_H2 CHG_OUT_H2 CHG_IN_H2 22Meg
CFB_H2 CHG_OUT_H2 CHG_IN_H2 470p
RIN_H2 PVDF_H2 CHG_IN_H2 100k
RS1A_H2 CHG_OUT_H2 S1_A_H2 14.7k
RS1B_H2 S1_A_H2 S1_B_H2 14.7k
CS1FB_H2 S1_A_H2 S1_OUT_H2 12n
CS1G_H2 S1_B_H2 VMID1V25 10n
RS2A_H2 S1_OUT_H2 S2_A_H2 27.4k
RS2B_H2 S2_A_H2 S2_B_H2 27.4k
CS2FB_H2 S2_A_H2 S2_OUT_H2 15n
CS2G_H2 S2_B_H2 VMID1V25 2.2n
RPD_H2 PRESS_H2 0 10k
DCLP_H2 CHG_IN_H2 VMID1V25 BAV199
DCLN_H2 VMID1V25 CHG_IN_H2 BAV199
CPV_H2 PVDF_H2 0 531p
CCABLE_H2 PVDF_H2 0 150p
CLOAD_H2 S2_OUT_H2 0 5p
BPC_H2 VEXC2V5 PRESS_H2 I=V(VEXC2V5,PRESS_H2)*V(contact_conductance)
.ic v(PVDF_H2)=1.25
.ic v(CHG_IN_H2)=1.25
.ic v(CHG_OUT_H2)=1.25
.ic v(S1_A_H2)=1.25
.ic v(S1_B_H2)=1.25
.ic v(S1_OUT_H2)=1.25
.ic v(S2_A_H2)=1.25
.ic v(S2_B_H2)=1.25
.ic v(S2_OUT_H2)=1.25
.include "[original source path]/MCP6001-rev-C.lib"
.include "[original source path]/BAV199.lib"
.include "[original source path]/OPAx320-prefixed.lib"
.options method=gear reltol=1e-4 abstol=1e-12 gmin=1e-13 maxord=2 itl1=500 itl4=100
.temp 27
.control
set wr_singlescale
set wr_vecnames
set numdgt=12
save v(VEXC2V5) v(VMID1V25) v(ADC_AIN_n) v(S2_OUT_I1) v(S2_OUT_I2) v(S2_OUT_H2) v(CHG_OUT_I1) v(PRESS_I1) v(VEXC_DRV)
tran 2u 135m 0 2u
let actual_simulation_end=time[length(time)-1]
print actual_simulation_end
wrdata waveform.dat v(VEXC2V5) v(VMID1V25) v(ADC_AIN_n) v(S2_OUT_I1) v(S2_OUT_I2) v(S2_OUT_H2) v(CHG_OUT_I1) v(PRESS_I1) v(VEXC_DRV)
quit
.endc
.end
